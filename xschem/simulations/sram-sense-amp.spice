** sch_path: /foss/designs/sram-sense-amp/xschem/sram-sense-amp.sch
**.subckt sram-sense-amp
V1 VDD GND {VDD}
V4 SE GND PULSE(0 {VDD} {T_read + D_se} {T_rise} {T_rise} 1n 10n)
XM8 net2 SE GND GND sg13_lv_nmos w=0.15u l=0.13u ng=1 m=1
XM9 OUT net3 VDD VDD sg13_lv_pmos w=0.15u l=0.13u ng=1 m=1
XM1 net1 BLB net2 net2 sg13_lv_nmos w=0.15u l=0.13u ng=1 m=1
XM3 net3 net1 VDD VDD sg13_lv_pmos w=0.15u l=0.13u ng=1 m=1
XM2 net1 net1 VDD VDD sg13_lv_pmos w=0.15u l=0.13u ng=1 m=1
XM6 OUT net3 GND GND sg13_lv_nmos w=0.15u l=0.13u ng=1 m=1
XM4 net3 BL net2 net2 sg13_lv_nmos w=0.15u l=0.13u ng=1 m=1
XM5 q qbar VDD VDD sg13_lv_pmos w=0.15u l=0.13u ng=1 m=1
XM7 qbar q VDD VDD sg13_lv_pmos w=0.15u l=0.13u ng=1 m=1
XM10 q qbar GND GND sg13_lv_nmos w=0.15u l=0.13u ng=1 m=1
XM11 qbar q GND GND sg13_lv_nmos w=0.15u l=0.13u ng=1 m=1
XM12 BL WL q GND sg13_lv_nmos w=0.15u l=0.13u ng=1 m=1
XM13 BLB WL qbar GND sg13_lv_nmos w=0.15u l=0.13u ng=1 m=1
C1 BL GND 0.5p m=1
C2 BLB GND 0.5p m=1
V5 WL GND PULSE(0 {VDD} {T_read} {T_rise} {T_rise} 2n 10n)
**** begin user architecture code

.lib cornerMOSlv.lib mos_tt

.param VDD=1.2
.param T_read=2n
.param T_rise=100p
.param D_se=500p

.ic v(BL)=VDD v(BLB)=VDD v(Q)=VDD V(qbar)=0

.tran 0.1p 10n

.control
run
set wr_singlescale
set wr_vecnames
wrdata data.txt v(BL) v(BLB) v(WL) v(SE) v(OUT)
.endc

**** end user architecture code
**.ends
.GLOBAL GND
.end
