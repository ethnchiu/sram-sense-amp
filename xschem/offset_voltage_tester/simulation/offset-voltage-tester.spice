** sch_path: /foss/designs/sram-sense-amp/xschem/offset_voltage_tester/offset-voltage-tester.sch
**.subckt offset-voltage-tester
XM8 net1 SE GND GND sg13_lv_nmos w=4*0.15u l=0.13u ng=1 m=1
XM1 Voutp Voutn net1 net1 sg13_lv_nmos w=5*0.15u l=0.13u ng=1 m=1
XM3 Voutn Voutp VDD VDD sg13_lv_pmos w=0.15u l=0.13u ng=1 m=1
XM2 Voutp Voutn VDD VDD sg13_lv_pmos w=0.15u l=0.13u ng=1 m=1
XM4 Voutn Voutp net1 net1 sg13_lv_nmos w=5*0.15u l=0.13u ng=1 m=1
XM6 Voutp SE BL VDD sg13_lv_pmos w=0.15u l=0.13u ng=1 m=1
XM9 Voutn SE BLB VDD sg13_lv_pmos w=0.15u l=0.13u ng=1 m=1
* noconn SE
* noconn BLB
* noconn BL
C1 BL GND 0.5p m=1
C2 BLB GND 0.5p m=1
**** begin user architecture code

.lib cornerMOSlv.lib mos_tt_mismatch

.param mm_ok=1
.param mc_ok=1
.param temp=27

.param VDD=1.2
.param VCM=1.2
.param vind=0

.param TPER=10n
.param TSE_DLY=4n
.param TSE_W=3n
.param TR=100p
.param TF=100p
.param TEVAL=6.5n

VDD_S VDD 0 {VDD}
*VSE SE 0 {VDD}
* Force SE high
VSE SE 0 PULSE(0 {VDD} {TSE_DLY} {TR} {TF} {TSE_W} {TPER})
* SE Pulse:
* 0V -> VDD @ TSE_DLY
* Stays high for TSE_W
* Repeats every TPER

B_BLDRV BLDRV 0 V = {VCM + vind / 2}
B_BLBDRV BLBDRV 0 V = {VCM - vind / 2}

RBL BLDRV BL 50
RBLB BLBDRV BLB 50

.control

set noaskquit
set numdgt=10

let mc_runs = 3
let run = 0

set curplot = new
set scratch = $curplot
setplot $scratch

let vos_r_vec = unitvec(mc_runs)
let vos_f_vec = unitvec(mc_runs)
let indices = unitvec(mc_runs)

dowhile run < mc_runs
    source /foss/designs/sram-sense-amp/xschem/offset_voltage_tester/offset_voltage_tester.sp
    let indices[run] = run
    let run = run + 1
end

setscale indices
set wr_vecnames
wrdata vos_r.out vos_r_vec
wrdata vos_f.out vos_f_vec

write vos_results.raw

echo
print {$scratch}.vos_r_vec
print {$scratch}.vos_f_vec

*let vos_avg = (vos_r + vos_f) / 2
*let vos_diff = vos_r - vos_f

*echo 'vos_r = ' $&vos_r
*echo 'vos_f = ' $&vos_f
*echo 'diff  = ' $&vos_diff
.endc

**** end user architecture code
**.ends
.GLOBAL GND
.end
