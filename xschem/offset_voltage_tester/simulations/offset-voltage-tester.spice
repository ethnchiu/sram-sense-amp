** sch_path: /foss/designs/sram-sense-amp/xschem/offset_voltage_tester/offset-voltage-tester.sch
**.subckt offset-voltage-tester
XM8 net1 SE GND GND sg13_lv_nmos w=4*0.15u l=0.13u ng=1 m=1
XM1 Voutp Voutn net1 net1 sg13_lv_nmos w=5*0.15u l=0.13u ng=1 m=1
XM3 Voutn Voutp VDD VDD sg13_lv_pmos w=0.15u l=0.13u ng=1 m=1
XM2 Voutp Voutn VDD VDD sg13_lv_pmos w=0.15u l=0.13u ng=1 m=1
XM4 Voutn Voutp net1 net1 sg13_lv_nmos w=5*0.15u l=0.13u ng=1 m=1
XM6 Voutp SE BL VDD sg13_lv_pmos w=0.15u l=0.13u ng=1 m=1
XM9 Voutn SE BLB VDD sg13_lv_pmos w=0.15u l=0.13u ng=1 m=1
* noconn SE
* noconn BLB
* noconn BL
C1 BL GND 0.5p m=1
C2 BLB GND 0.5p m=1
**** begin user architecture code

.lib cornerMOSlv.lib mos_tt_mismatch

.param mm_ok=1
.param mc_ok=1
.param temp=27

.param VDD=1.2
.param VCM=1.175
.param VIND_INIT=0

.param TPER=10n
.param TSE_DLY=4n
.param TSE_W=3n
.param TR=100p
.param TF=100p
.param TEVAL=6.5n

VDD_S VDD 0 {VDD}

* SE Pulse:
* 0V -> VDD @ TSE_DLY
* Stays high for TSE_W
* Repeats every TPER
VSE SE 0 PULSE(0 {VDD} {TSE_DLY} {TR} {TF} {TSE_W} {TPER})

VVIND VIND_CTRL 0 {VIND_INIT}

B_BLDRV BLDRV 0 V = {VCM + v(VIND_CTRL) / 2}
B_BLBDRV BLBDRV 0 V = {VCM - v(VIND_CTRL) / 2}

RBL BLDRV BL 50
RBLB BLBDRV BLB 50

.control

set noaskquit
set numdgt=10
set wr_singlescale
set wr_vecnames

let mc_runs = 500

let vin_min = -0.05
let vin_max = 0.05
let vind_range = vin_max - vin_min
let nbit = 10
let voutd_th = 0

let tstep = 20p
let tper = 10n
let teval = 6.5n

let max_cycles = 4 * nbit + 4
let tstop = max_cycles * tper

setplot new
set scratch = $curplot

let run = 0
dowhile run < mc_runs
    source /foss/designs/sram-sense-amp/xschem/offset_voltage_tester/offset_voltage_tester.sp

    let run = run + 1
end

rusage time

.endc

**** end user architecture code
**.ends
.GLOBAL GND
.end
